{
    name      : "SPI",
    width     : 8,
    desc      : "CSR for SPI"
    interface : "sbi"

    parameters : [
    	{
	    name         : "USER_DEFINE_PRESCALER"
	    desc         : "Parameters to use the enable the User define Prescaler"
	    type         : "boolean"
	}
    	{
	    name         : "PRESCALER_RATIO"
	    desc         : "Default value for prescaler ratio"
	    type         : "std_logic_vector(7 downto 0)"
	}
	{
	    name         : "DEPTH_TX"
	    desc         : "Depth of FIFO TX (SW2HW)"
	    type         : "natural"
	}
	{
	    name         : "DEPTH_RX"
	    desc         : "Depth of FIFO RX (HW2SW)"
	    type         : "natural"
	}
	{
	    name         : "DEPTH_CMD"
	    desc         : "Depth of FIFO Command (SW2HW)"
	    type         : "natural"
	}
    ]

    registers : [
        {
            name         : "data",
            address      : "x0",
            desc         : "Write : data to tansmit, Read : data to receive",
            swaccess     : "rw",
            hwaccess     : "rw",
            hwtype       : "fifo",

            params: {
                BLOCKING_READ  : "True", 
                BLOCKING_WRITE : "True",
                DEPTH_SW2HW    : "DEPTH_TX"
                DEPTH_HW2SW    : "DEPTH_RX"
            }

            fields: [
                {
                    name: "value",
                    bits: "7:0",
                    desc: "Data TX or Data RX"
                },
            ]
        },

        {
            name         : "cmd",
            address      : "x1",
            desc         : "Command FIFO",
            swaccess     : "wo",
            hwaccess     : "ro",
            hwtype       : "fifo",

            params: {
                BLOCKING_READ  : "True", 
                BLOCKING_WRITE : "True",
                DEPTH_SW2HW    : "DEPTH_CMD"
            }

            fields: [
                {
                    name: "nb_bytes",
                    bits: "1:0",
                    desc: "Transfert Length in bytes (N+1)"
                },
                {
                    name: "size",
                    bits: "3:2",
                    desc: "Transfert Size : 1/2/4/8"

                    enum: [
                        {value:"0", name:"SINGLE",desc:"SPI SINGLE Legacy (MISO/MOSI) mode"},
                        {value:"1", name:"DUAL"  ,desc:"SPI DUAL (2b) mode"},
                        {value:"2", name:"QUAD"  ,desc:"SPI QUAD (4b) mode"},
                        {value:"3", name:"OCTAL" ,desc:"SPI OCTAL (8b) mode"},
                    ]
                },
                {
                    name: "enable_rx",
                    bits: "4",
                    desc: "Push in RX FIFO - 0 : don't push in RX FIFO, 1 : push in RX FIFO when receive byte"

                    enum: [
                        {value:"0", name:"DISABLE",desc:"don't push in RX FIFO"},
                        {value:"1", name:"ENABLE" ,desc:"push in RX FIFO when receive byte"},
                    ]

                },
                {
                    name: "enable_tx",
                    bits: "5",
                    desc: "POP from TX FIFO - 0 : don't pop TX FIFO and keep mosi_oe to 0, 1 pop TX FIFO and mosi_oe_o is 1 during the transfert"
                    enum: [
                        {value:"0", name:"DISABLE",desc:"don't pop TX FIFO and keep mosi_oe to 0"},
                        {value:"1", name:"ENABLE" ,desc:"pop TX FIFO and mosi_oe_o is 1 during the transfert"},
                    ]
                },
                {
                    name: "last",
                    bits: "6",
                    desc: "Last Transfert - 0 : not last cs keep active after transfer, 1 : last packet to transfer cs go inactive after transfer. SPECIAL CASE if last = enable_rx = enable_tx = 0 then stop the transfert"
                    enum: [
                        {value:"0", name:"DISABLE",desc:"not last cs keep active after transfer"},
                        {value:"1", name:"ENABLE" ,desc:"last packet to transfer cs go inactive after transfer. SPECIAL CASE if last = enable_rx = enable_tx = 0 then stop the transfert"},
                    ]
                },
                {
                    name: "cfg",
                    bits: "7",
                    desc: "Configuration - 0 : configure enable_tx/enable_rx and size, 1 : replace enable_tx/enable_rx and size by nb_bytes[5:2]"
                    enum: [
                        {value:"0", name:"CONFIG",desc:"configure enable_tx/enable_rx and size"},
                        {value:"1", name:"KEEP"  ,desc:"replace enable_tx/enable_rx and size by nb_bytes[5:2]"},
                    ]
                },
            ]


        },

	{
            name         : "cfg",
            address      : "x2",
            desc         : "SPI Configuration Register",
            swaccess     : "rw",
            hwaccess     : "ro",

            fields: [
                {
                    name: "spi_enable",
                    bits: "0",
                    desc: "0 : SPI master is disabled (held in reset) : a transfer in progress is aborted, CS# is driven high and SCLK to CPOL, the pending commands and TX bytes are dropped (the RX bytes stay in the RX FIFO). 1 : SPI master is enabled"
                },
                {
                    name: "cpol",
                    bits: "1",
                    desc: "Clock Polarity"
                },
                {
                    name: "cpha",
                    bits: "2",
                    desc: "Clock Phase"
                },
                {
                    name: "loopback",
                    bits: "3",
                    desc: "0 : MISO is connected to SPI MISO, 1 MISO is connected to MOSI"
                },
                
                //{
                //    name: "cs",
                //    bits: "7:4",
                //    desc: "Chip Select"
                //},
            ]
        },

	{
            name         : "prescaler",
            address      : "x3",
            desc         : "SPI Clock Prescaler. SCLK Frequency is CLK / 2*(prescaler+1)"
            swaccess     : "rw",
            hwaccess     : "ro",
            hwtype       : "reg",
            enable       : "USER_DEFINE_PRESCALER",

            fields: [
                {
                    name: "ratio",
                    bits: "7:0",
                    desc: "Baud Tick Counter Max"
                    expr: "PRESCALER_RATIO"
                },
            ]
        },

	{
            name         : "status",
            address      : "x1",
            desc         : "SPI Status Register (read only, writes are ignored). data and cmd are blocking FIFO registers : check tx_full / cmd_full before a write and rx_empty before a read to never stall the bus"
            swaccess     : "ro",
            hwaccess     : "rw",
            hwtype       : "ext",

            fields: [
                {
                    name: "tx_empty",
                    bits: "0",
                    desc: "1 : TX FIFO (data write) is empty"
                },
                {
                    name: "tx_full",
                    bits: "1",
                    desc: "1 : TX FIFO (data write) is full, a write to data waits until the SPI master pops a byte (always 1 with DEPTH_TX=0 outside the master handshake)"
                },
                {
                    name: "rx_empty",
                    bits: "2",
                    desc: "1 : RX FIFO (data read) is empty, a read of data waits until the SPI master pushes a byte"
                },
                {
                    name: "rx_full",
                    bits: "3",
                    desc: "1 : RX FIFO (data read) is full, the SPI master waits for a read of data before receiving the next byte"
                },
                {
                    name: "cmd_empty",
                    bits: "4",
                    desc: "1 : Command FIFO is empty"
                },
                {
                    name: "cmd_full",
                    bits: "5",
                    desc: "1 : Command FIFO is full, a write to cmd waits until the SPI master pops a command (always 1 with DEPTH_CMD=0 outside the master handshake)"
                },
                {
                    name: "busy",
                    bits: "6",
                    desc: "1 : SPI transaction in progress (CS# active or SPI master not idle) or command pending, 0 : all commands are done and CS# is released"
                },
            ]
        },
]
}
